simulator( 'spectre )
design(	 "/home/disk/simulation/SIM_IC61/CMOSinverter_Simulation/spectre/schematic/netlist/netlist")
resultsDir( "/home/disk/simulation/SIM_IC61/CMOSinverter_Simulation/spectre/schematic" )
modelFile(
    '("/home/work/gpdk090_v4.6/libs.oa22/gpdk090/../../models/spectre/gpdk090.scs" "NN")
    '("/home/work/gpdk045_v_5_0/gpdk045/../models/spectre/gpdk045.scs" "mc")
)
analysis('tran ?stop "100n"  ?errpreset "moderate"  )
analysis('dc ?saveOppoint t  ?dev "/V1"  ?param "dc"
		?start "0"  ?stop "1"  )
envOption(
	'analysisOrder  list("tran" "dc")
)
save( 'i "/I0/VDD" )
temp( 27 )
run()
selectResult( 'dc )
plot(getData("/Vin") getData("/Vout") getData("/I0/VDD") )
selectResult( 'tran )
plot(getData("/Vin") getData("/Vout") getData("/I0/VDD") )
modelFile(
    '("/home/work/gpdk090_v4.6/libs.oa22/gpdk090/../../models/spectre/gpdk090.scs" "NN")
    '("/home/work/gpdk045_v_5_0/gpdk045/../models/spectre/gpdk045.scs" "mc")
)
run()
selectResult( 'dc )
plot(getData("/Vin") getData("/Vout") getData("/I0/VDD") )
selectResult( 'tran )
plot(getData("/Vin") getData("/Vout") getData("/I0/VDD") )
modelFile(
    '("/home/work/gpdk090_v4.6/libs.oa22/gpdk090/../../models/spectre/gpdk090.scs" "NN")
    '("/home/work/gpdk045_v_5_0/gpdk045/../models/spectre/gpdk045.scs" "mc")
)
run()
selectResult( 'dc )
plot(getData("/Vin") getData("/Vout") getData("/I0/VDD") )
selectResult( 'tran )
plot(getData("/Vin") getData("/Vout") getData("/I0/VDD") )
